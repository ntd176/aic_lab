*** SPICE deck for cell current_mirror{lay} from library bai_7
*** Created on Wed Feb 04, 2026 20:58:05
*** Last revised on Wed Feb 04, 2026 21:13:42
*** Written on Wed Feb 04, 2026 21:28:55 by Electric VLSI Design System, version 9.08
*** Layout tech: mocmos, foundry MOSIS
*** UC SPICE *** , MIN_RESIST 4.0, MIN_CAPAC 0.1FF
***    P-Active:	areacap=0.9FF/um^2,	edgecap=0.0FF/um,	res=2.5ohms/sq
***    N-Active:	areacap=0.9FF/um^2,	edgecap=0.0FF/um,	res=3.0ohms/sq
***    Polysilicon-1:	areacap=0.1467FF/um^2,	edgecap=0.0608FF/um,	res=6.2ohms/sq
***    Polysilicon-2:	areacap=1.0FF/um^2,	edgecap=0.0FF/um,	res=50.0ohms/sq
***    Transistor-Poly:	areacap=0.09FF/um^2,	edgecap=0.0FF/um,	res=2.5ohms/sq
***    Poly-Cut:	areacap=0.0FF/um^2,	edgecap=0.0FF/um,	res=2.2ohms/sq
***    Active-Cut:	areacap=0.0FF/um^2,	edgecap=0.0FF/um,	res=2.5ohms/sq
***    Metal-1:	areacap=0.1209FF/um^2,	edgecap=0.1104FF/um,	res=0.078ohms/sq
***    Via1:	areacap=0.0FF/um^2,	edgecap=0.0FF/um,	res=1.0ohms/sq
***    Metal-2:	areacap=0.0843FF/um^2,	edgecap=0.0974FF/um,	res=0.078ohms/sq
***    Via2:	areacap=0.0FF/um^2,	edgecap=0.0FF/um,	res=0.9ohms/sq
***    Metal-3:	areacap=0.0843FF/um^2,	edgecap=0.0974FF/um,	res=0.078ohms/sq
***    Via3:	areacap=0.0FF/um^2,	edgecap=0.0FF/um,	res=0.8ohms/sq
***    Metal-4:	areacap=0.0843FF/um^2,	edgecap=0.0974FF/um,	res=0.078ohms/sq
***    Via4:	areacap=0.0FF/um^2,	edgecap=0.0FF/um,	res=0.8ohms/sq
***    Metal-5:	areacap=0.0843FF/um^2,	edgecap=0.0974FF/um,	res=0.078ohms/sq
***    Via5:	areacap=0.0FF/um^2,	edgecap=0.0FF/um,	res=0.8ohms/sq
***    Metal-6:	areacap=0.0423FF/um^2,	edgecap=0.1273FF/um,	res=0.036ohms/sq
***    Hi-Res:	areacap=0.0FF/um^2,	edgecap=0.0FF/um,	res=1.0ohms/sq

*** TOP LEVEL CELL: current_mirror{lay}
MM1 Iref Iref gnd gnd NMOS L=0.6U W=3U AS=26.325P AD=5.4P PS=36.6U PD=9.6U
MM2 Iout Iref gnd gnd NMOS L=0.6U W=15U AS=27P AD=26.325P PS=33.6U PD=36.6U
** Extracted Parasitic Capacitors ***
C0 net@1#5M1_poly-left 0 0.165fF
C1 net@1 0 2.272fF
C2 Iout 0 3.567fF
C3 net@1#3pin@2_polysilicon-1 0 0.226fF
C4 net@1#4pin@3_polysilicon-1 0 0.226fF
C5 net@1#7pin@5_polysilicon-1 0 0.234fF
** Extracted Parasitic Resistors ***
R0 net@1#2M2_poly-left net@1#3pin@2_polysilicon-1 6.2
R1 net@1#4pin@3_polysilicon-1 net@1#5M1_poly-left 6.2
R2 net@1#3pin@2_polysilicon-1 net@1#3pin@2_polysilicon-1##0 8.956
C6 net@1#3pin@2_polysilicon-1##0 0 0.164fF
R3 net@1#3pin@2_polysilicon-1##0 net@1#3pin@2_polysilicon-1##1 8.956
C7 net@1#3pin@2_polysilicon-1##1 0 0.164fF
R4 net@1#3pin@2_polysilicon-1##1 net@1#3pin@2_polysilicon-1##2 8.956
C8 net@1#3pin@2_polysilicon-1##2 0 0.164fF
R5 net@1#3pin@2_polysilicon-1##2 net@1#3pin@2_polysilicon-1##3 8.956
C9 net@1#3pin@2_polysilicon-1##3 0 0.164fF
R6 net@1#3pin@2_polysilicon-1##3 net@1#3pin@2_polysilicon-1##4 8.956
C10 net@1#3pin@2_polysilicon-1##4 0 0.164fF
R7 net@1#3pin@2_polysilicon-1##4 net@1#3pin@2_polysilicon-1##5 8.956
C11 net@1#3pin@2_polysilicon-1##5 0 0.164fF
R8 net@1#3pin@2_polysilicon-1##5 net@1#3pin@2_polysilicon-1##6 8.956
C12 net@1#3pin@2_polysilicon-1##6 0 0.164fF
R9 net@1#3pin@2_polysilicon-1##6 net@1#3pin@2_polysilicon-1##7 8.956
C13 net@1#3pin@2_polysilicon-1##7 0 0.164fF
R10 net@1#3pin@2_polysilicon-1##7 net@1#4pin@3_polysilicon-1 8.956
R11 net@1#5M1_poly-left net@1#5M1_poly-left##0 6.717
C14 net@1#5M1_poly-left##0 0 0.102fF
R12 net@1#5M1_poly-left##0 net@1#5M1_poly-left##1 6.717
C15 net@1#5M1_poly-left##1 0 0.102fF
R13 net@1#5M1_poly-left##1 net@1#7pin@5_polysilicon-1 6.717
R14 net@1#7pin@5_polysilicon-1 net@1#7pin@5_polysilicon-1##0 8.138
C16 net@1#7pin@5_polysilicon-1##0 0 0.132fF
R15 net@1#7pin@5_polysilicon-1##0 net@1#7pin@5_polysilicon-1##1 8.138
C17 net@1#7pin@5_polysilicon-1##1 0 0.132fF
R16 net@1#7pin@5_polysilicon-1##1 net@1#7pin@5_polysilicon-1##2 8.138
C18 net@1#7pin@5_polysilicon-1##2 0 0.132fF
R17 net@1#7pin@5_polysilicon-1##2 net@1 8.138

* Spice Code nodes in cell cell 'current_mirror{lay}'
.include "E:\Analog_IC_Design\ThucHanh\K22_TKVMTT\Electric_2025\libs\models\C5_models.txt"
Vsupply V1 0 DC 5V
RR1 V1 Iref 35k
RR2 V1 Iout 9k
.noise v(Iout) V1 dec 1000 10G 100G
V1 Iref GND 1V AC 1V SINE(1V 1V 800Meg 1n)
.probe V(onoise)
.END
