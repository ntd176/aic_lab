*** SPICE deck for cell ESD_HBM_Testbench_1{sch} from library bai_8
*** Created on Sun Feb 15, 2026 21:05:15
*** Last revised on Sun Feb 15, 2026 21:10:19
*** Written on Sun Feb 15, 2026 21:11:04 by Electric VLSI Design System, version 9.08
*** Layout tech: mocmos, foundry MOSIS
*** UC SPICE *** , MIN_RESIST 4.0, MIN_CAPAC 0.1FF

*** SUBCIRCUIT bai_8__ESD_HBM FROM CELL ESD_HBM{sch}
.SUBCKT bai_8__ESD_HBM ESD gnd
** GLOBAL gnd
CESD_C1 gnd esd_c1 0.15n
CESD_C2 gnd esd_c2 8p
LESD_L1 esd_r1 ESD 2.4u
LESD_L2 esd_r2 ESD 0.14u
RESD_R1 esd_r1 esd_c1 330
RESD_R2 esd_r2 esd_c2 200
RESD_R3 ESD gnd 390

* Spice Code nodes in cell cell 'ESD_HBM{sch}'
.param vnom = 2*2000
.ic v(esd_c1) = vnom
.ic v(esd_c2) = vnom
.ENDS bai_8__ESD_HBM

*** SUBCIRCUIT bai_8__inv FROM CELL inv{sch}
.SUBCKT bai_8__inv A B gnd vdd
** GLOBAL gnd
** GLOBAL vdd
MQ0 B A vdd vdd PMOS L=0.6U W=2.4U
MQ1 B A gnd gnd NMOS L=0.6U W=1.2U
.ENDS bai_8__inv

.global gnd vdd

*** TOP LEVEL CELL: ESD_HBM_Testbench_1{sch}
XESD_HBM@0 A gnd bai_8__ESD_HBM
Xinv@0 A B gnd vdd bai_8__inv

* Spice Code nodes in cell cell 'ESD_HBM_Testbench_1{sch}'
.include "E:\Analog_IC_Design\ThucHanh\K22_TKVMTT\Electric_2025\libs\models\C5_models.txt"
.trans 0 1us 1ns
VVDD VDD GND 5V
CCL GND B 1u
.END
