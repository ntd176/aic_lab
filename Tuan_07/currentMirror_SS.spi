*** SPICE deck for cell currentMirror_SS{sch} from library bai_5
*** Created on Fri Nov 14, 2025 16:00:34
*** Last revised on Fri Nov 14, 2025 16:01:10
*** Written on Fri Nov 14, 2025 16:01:17 by Electric VLSI Design System, version 9.08
*** Layout tech: mocmos, foundry MOSIS
*** UC SPICE *** , MIN_RESIST 4.0, MIN_CAPAC 0.1FF

.global gnd

*** TOP LEVEL CELL: currentMirror_SS{sch}
MM1 M1_d net@2 gnd gnd nch L=0.2U W=0.4U
MM2 net@5 net@2 gnd gnd nch L=0.2U W=2U
RR1 net@2 net@0 10k
RR2 net@5 net@0 3k1
VV1 net@0 gnd DC 1.8

* Spice Code nodes in cell cell 'currentMirror_SS{sch}'
.lib 'E:\Analog_IC_Design\ThucHanh\K22_TKVMTT\Electric_2025\libs\models\tsmc180nm\mm018.l' SS
.op
.probe i()
.step VV1 1.7 1.9 0.1
.END
