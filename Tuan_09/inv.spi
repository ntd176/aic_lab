*** SPICE deck for cell inv{lay} from library bai_7
*** Created on Sat Dec 21, 2024 11:52:36
*** Last revised on Tue Dec 16, 2025 13:30:04
*** Written on Wed Feb 04, 2026 15:17:20 by Electric VLSI Design System, version 9.08
*** Layout tech: mocmos, foundry MOSIS
*** UC SPICE *** , MIN_RESIST 4.0, MIN_CAPAC 0.1FF
***    P-Active:	areacap=0.9FF/um^2,	edgecap=0.0FF/um,	res=2.5ohms/sq
***    N-Active:	areacap=0.9FF/um^2,	edgecap=0.0FF/um,	res=3.0ohms/sq
***    Polysilicon-1:	areacap=0.1467FF/um^2,	edgecap=0.0608FF/um,	res=6.2ohms/sq
***    Polysilicon-2:	areacap=1.0FF/um^2,	edgecap=0.0FF/um,	res=50.0ohms/sq
***    Transistor-Poly:	areacap=0.09FF/um^2,	edgecap=0.0FF/um,	res=2.5ohms/sq
***    Poly-Cut:	areacap=0.0FF/um^2,	edgecap=0.0FF/um,	res=2.2ohms/sq
***    Active-Cut:	areacap=0.0FF/um^2,	edgecap=0.0FF/um,	res=2.5ohms/sq
***    Metal-1:	areacap=0.1209FF/um^2,	edgecap=0.1104FF/um,	res=0.078ohms/sq
***    Via1:	areacap=0.0FF/um^2,	edgecap=0.0FF/um,	res=1.0ohms/sq
***    Metal-2:	areacap=0.0843FF/um^2,	edgecap=0.0974FF/um,	res=0.078ohms/sq
***    Via2:	areacap=0.0FF/um^2,	edgecap=0.0FF/um,	res=0.9ohms/sq
***    Metal-3:	areacap=0.0843FF/um^2,	edgecap=0.0974FF/um,	res=0.078ohms/sq
***    Via3:	areacap=0.0FF/um^2,	edgecap=0.0FF/um,	res=0.8ohms/sq
***    Metal-4:	areacap=0.0843FF/um^2,	edgecap=0.0974FF/um,	res=0.078ohms/sq
***    Via4:	areacap=0.0FF/um^2,	edgecap=0.0FF/um,	res=0.8ohms/sq
***    Metal-5:	areacap=0.0843FF/um^2,	edgecap=0.0974FF/um,	res=0.078ohms/sq
***    Via5:	areacap=0.0FF/um^2,	edgecap=0.0FF/um,	res=0.8ohms/sq
***    Metal-6:	areacap=0.0423FF/um^2,	edgecap=0.1273FF/um,	res=0.036ohms/sq
***    Hi-Res:	areacap=0.0FF/um^2,	edgecap=0.0FF/um,	res=1.0ohms/sq

*** TOP LEVEL CELL: inv{lay}
Mnmos@0 gnd A#3nmos@0_poly-right B gnd NMOS L=0.6U W=1.2U AS=3.465P AD=9.36P PS=7.5U PD=18.6U
Mpmos@1 vdd A#1pmos@1_poly-left B vdd PMOS L=0.6U W=2.4U AS=3.465P AD=11.52P PS=7.5U PD=21U
** Extracted Parasitic Capacitors ***
C0 B 0 4.116fF
C1 A 0 3.686fF
C2 A#3nmos@0_poly-right 0 0.134fF
C3 A#1pmos@1_poly-left 0 0.126fF
** Extracted Parasitic Resistors ***
R0 A#1pmos@1_poly-left A#1pmos@1_poly-left##0 8.267
C4 A#1pmos@1_poly-left##0 0 0.126fF
R1 A#1pmos@1_poly-left##0 A#1pmos@1_poly-left##1 8.267
C5 A#1pmos@1_poly-left##1 0 0.126fF
R2 A#1pmos@1_poly-left##1 A 8.267
R3 A A##0 8.783
C6 A##0 0 0.134fF
R4 A##0 A##1 8.783
C7 A##1 0 0.134fF
R5 A##1 A#3nmos@0_poly-right 8.783

* Spice Code nodes in cell cell 'inv{lay}'
.include "E:\Analog_IC_Design\ThucHanh\K22_TKVMTT\Electric_2025\libs\models\C5_models.txt"
.ac dec 1000 10 10G
.probe v(B)
.meas ac tmp max mag(v(B))
.meas ac fcut when mag(v(B)) = tmp/sqrt(2)
VVDD VDD GND 3.3V
VA A gnd DC=1V AC=1V SIN(1V 1V 800MEG 1ns)
CCL gnd B 100n
.END
